# Ansys Electronics Desktop project, version 2017.0
materials:
  D21_50: permeability{BType=normal HUnit=A_per_meter BUnit=tesla curve (0, 0) (140, 0.4) (155, 0.45) (171, 0.5) (191, 0.55) (212, 0.6) (237, 0.65) (267, 0.7) (302, 0.75) (340, 0.8) (380, 0.85) (425, 0.9) (476, 0.95) (536, 1) (602, 1.05) (675, 1.1) (765, 1.15) (880, 1.2) (1020, 1.25) (1200, 1.3) (1450, 1.35) (1740, 1.4) (2160, 1.45) (2800, 1.5) (3850, 1.55) (5290, 1.6) (6920, 1.65) (8800, 1.7) (11000, 1.75) (13800, 1.8) (17300, 1.85) (21400, 1.9) (25000, 1.95) (30000, 2)} core_loss_type="Electrical Steel" core_loss_kh=366 core_loss_kc=0.822 core_loss_ke=0.91 mass_density=7820
  copper: permeability=0.999991 conductivity=58000000 mass_density=8933

design RMxprtDesign1 (RMxprt, Three Phase Induction Motor, model units mm)
machine:
  Machine: FrictionLoss=20W WindLoss=20W ReferenceSpeed=1520rpm NumberOfPoles=6 StrayLossFactor=0.01
  Stator: SkewWidth=0 NumberOfSlots=54 LaminationSectors=3 PressBoardThickness=0mm OuterDiameter=748.65mm InnerDiameter=639mm Length=482.3mm StackingFactor=0.95 SteelType=D21_50 SlotType=4
  Rotor: OuterDiameter=637mm InnerDiameter=523.15mm Length=482.3mm SteelType=D21_50 NumberOfSlots=72 SlotType=4 SkewWidth=2 CastRotor BottomSlotType=UserDefinedSlot StackingFactor=0.95
  Shaft:
  Stator Slot: Hs0=0.1mm Hs1=0.1mm Hs2=23mm Bs0=10mm Bs1=19mm Bs2=21.3mm Rs=0.1mm ToothWidth=0mm
  Stator Winding: WindingType=Whole-Coiled WindingLayers=2 ParallelBranches=1 ConductorsPerSlot=4 CoilPitch=8 EndAdjustment=0mm BaseInnerRadius=0mm TipInnerDiameter=0mm EndClearance=0mm CoilWrap=0mm SlotLiner=0mm WedgeThickness=0mm LayerInsulation=0mm BottomInsulation=0mm LimitedFillFactor=0.75 WdgNumberofPriodicMultipler=6 WdgConstantPitch WdgConstantTurns Wdgcoil_turns(2, 2, 2, 2, 2, 2, 2, 2, 2, 2, 2, 2, 2, 2, 2, 2, 2, 2, 2, 2, 2, 2, 2, 2, 2, 2, 2, 2, 2, 2, 2, 2, 2, 2, 2, 2, 2, 2, 2, 2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) Wdgcoil_name(A, A, A, -C, -C, -C, B, B, B, -A, -A, -A, C, C, C, -B, -B, -B, A, A, A, -C, -C, -C, B, B, B, -A, -A, -A, C, C, C, -B, -B, -B, A, A, A, -C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) Wdgcoil_go(1T, 2T, 3T, 4T, 5T, 6T, 7T, 8T, 9T, 10T, 11T, 12T, 13T, 14T, 15T, 16T, 17T, 18T, 19T, 20T, 21T, 22T, 23T, 24T, 25T, 26T, 27T, 28T, 29T, 30T, 31T, 32T, 33T, 34T, 35T, 36T, 37T, 38T, 39T, 40T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) Wdgcoil_re(18B, 19B, 20B, 21B, 22B, 23B, 24B, 25B, 26B, 27B, 28B, 29B, 30B, 31B, 32B, 33B, 34B, 35B, 36B, 37B, 38B, 39B, 40B, 41B, 42B, 43B, 44B, 45B, 46B, 47B, 48B, 49B, 50B, 51B, 52B, 53B, 54B, 1B, 2B, 3B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) NumberOfStrands=10 WireWrap=0mm InterturnInsulation=0mm WireDiameter=2.588mm WireWidth=0mm WireThickness=0mm Gauge=10
  Rotor Slot: Hs0=0.1mm Hs1=0.1mm Hs2=8.2mm Bs0=7mm Bs1=16mm Bs2=13.5mm Rs=0.1mm Hs01=0.1mm
  Rotor Winding: BarConductorType=copper EndLength=5mm EndRingWidth=5mm EndRingHeight=5mm EndRingConductorType=copper
setups:
  Setup1: TPIM Motor RatedOutputPower=1280000W RatedVoltage=1350V RatedSpeed=1520rpm OperatingTemperature=75cel LoadType=ConstPower Frequency=78Hz WindingConnection=0
